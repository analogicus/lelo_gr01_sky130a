*TB_SUN_TR_SKY130NM/TB_NCM
*----------------------------------------------------------------
* Include
*----------------------------------------------------------------
#ifdef Lay
.include ../../../work/lpe/GM_cell_N_lpe.spi
#else
.include ../../../work/xsch/GM_cell_N.spice
#endif

*-----------------------------------------------------------------
* OPTIONS
*-----------------------------------------------------------------
.option TNOM=27 GMIN=1e-15 reltol=1e-3

*-----------------------------------------------------------------
* PARAMETERS
*-----------------------------------------------------------------
.param TRF = 10p
.param vdda = 1.8
.param AVDD = {vdda}

*-----------------------------------------------------------------
* FORCE
*-----------------------------------------------------------------
VSS  VSS  0     dc 0
VDD_1V8  VDD_1V8  VSS  dc 1.8

*Place a load on IBP
Rload VDD_1V8 IBN 1000

*-----------------------------------------------------------------
* DUT
*-----------------------------------------------------------------
.include ../xdut.spi

*----------------------------------------------------------------
* PROBE
*----------------------------------------------------------------
.options savecurrents
.save all

*----------------------------------------------------------------
* NGSPICE control
*----------------------------------------------------------------
.control
load {cicname}.raw
set num_threads=8
set color0=white
set color1=black
unset askquit

.option savecurrents
.save v(vref) @m.xdut.x5.msky130_fd_pr__nfet_01v8_lvt[id]

optran 0 0 0 1n 1u 0
dc temp -40 125 1
write {cicname}_temp.raw

op
write {cicname}_op.raw

tran 10n 10u 1p
write
quit

.endc

.end
