*TB_SUN_TR_SKY130NM/TB_NCM
*----------------------------------------------------------------
* Include
*----------------------------------------------------------------
#ifdef Lay
.include ../../../work/lpe/LELO_GR01_lpe.spi
#else
.include ../../../work/xsch/LELO_GR01.spice
#endif

*-----------------------------------------------------------------
* OPTIONS
*-----------------------------------------------------------------
.option TNOM=25 GMIN=1e-15 reltol=1e-3 maxdatasizetotal=22GB

*-----------------------------------------------------------------
* PARAMETERS
*-----------------------------------------------------------------
.param TRF = 10p
.param vdda = 1.8
.param AVDD = {vdda}

.param TAMB = 25
.temp {TAMB}

*-----------------------------------------------------------------
* FORCE
*-----------------------------------------------------------------
VSS  VSS  0     dc 0
VDD_1V8  VDD_1V8  VSS  dc 1.8

*-----------------------------------------------------------------
* STARTUP/SHUTDOWN
*-----------------------------------------------------------------

* Slow startup and shutdown after 2us (for power consumption testing)
*VPWR  PWRUP_1V8  VSS  pwl 0 0 {t_start} 0 {{t_start}+0.5u} 0 {{t_start}+0.6u} {AVDD} {{t_start}+3u} {AVDD} {{t_start}+3.1u} 0
*VPWRN  PWRUP_N_1V8  VSS  pwl 0 {AVDD} {{t_start}+0.5u} {AVDD} {{t_start}+0.6u} {0} {{t_start}+3u} {0} {{t_start}+3.1u} {AVDD}

* Normal operation
VPWR  PWRUP_1V8  VSS  pwl 0 0 {t_start} 0 {{t_start}+10p} {AVDD}
VPWRN  PWRUP_N_1V8  VSS  pwl 0 {AVDD} {t_start} {AVDD} {{t_start}+10p} {0}

*-----------------------------------------------------------------
* DUT
*-----------------------------------------------------------------
.include ../xdut.spi

*----------------------------------------------------------------
* PROBE
*----------------------------------------------------------------
.options savecurrents
.save all
*----------------------------------------------------------------
* NGSPICE control
*----------------------------------------------------------------
.control
set num_threads=6
set color0=white
set color1=black
unset askquit

*op
optran 0 0 0 1n 1u 0
tran 0.5n 9u 1p
write

echo 'Temp ; Freq' > {cicname}_oscillator.csv

set temp_stop = 125
set temp_step = 15
set temp_val = -40

*Regular version set startup to 0u

while $temp_val le $temp_stop
  set temp = $temp_val

	tran 0.1n 4u
	*write {cicname}_temp_{$temp_val}.raw

  meas tran Tperiod  TRIG v(osc_temp_1v8) VAL=0.9 RISE=2  TARG v(osc_temp_1v8) VAL=0.9 RISE=3
  meas tran Iavg AVG i(VDD_1V8) from=0.1u to=4u

	let Freq = 1/Tperiod
	echo Temp = $temp_val C  freq = $&freq Hz
  let current_val = mag(Iavg)
  echo '$temp_val ; $&freq ; $&current_val' >> {cicname}_oscillator.csv

	let temp_next = $temp_val + $temp_step
	set temp_val = "$&temp_next"
end

*leakage version, set startup time to be > biggest sim time

*while $temp_val le $temp_stop
*    set temp = $temp_val
*
*    tran 0.1n 4u
*
** Measure average current (Leakage)
*    meas tran Ileak AVG i(VDD_1V8) from=0.1u to=4u
*
*    let Freq = 0
*    let current_val = mag(Ileak)
*
*    echo Temp = $temp_val C  Leakage = $&current_val A
*
** Save to CSV: Temp ; Freq(0) ; Current
*    echo '$&temp_val ; $&Freq ; $&current_val' >> {cicname}_leakage.csv
*
*    let temp_next = $temp_val + $temp_step
*    set temp_val = "$&temp_next"
*  end

quit

.endc

.end
