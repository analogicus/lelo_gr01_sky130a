*TB_SUN_TR_SKY130NM/TB_NCM
*----------------------------------------------------------------
* Include
*----------------------------------------------------------------
#ifdef Lay
.include ../../../work/lpe/LELO_GR01_lpe.spi
#else
.include ../../../work/xsch/LELO_GR01.spice
#endif

*-----------------------------------------------------------------
* OPTIONS
*-----------------------------------------------------------------
.option TNOM=27 GMIN=1e-15 reltol=1e-3

*-----------------------------------------------------------------
* PARAMETERS
*-----------------------------------------------------------------
.param TRF = 10p
.param vdda = 1.8
.param AVDD = {vdda}

.param TAMB = 40
.temp {TAMB}

*-----------------------------------------------------------------
* FORCE
*-----------------------------------------------------------------
VSS  VSS  0     dc 0
VDD_1V8  VDD_1V8  VSS  dc 1.8

*-----------------------------------------------------------------
* DUT
*-----------------------------------------------------------------
.include ../xdut.spi

*----------------------------------------------------------------
* PROBE
*----------------------------------------------------------------
.options savecurrents
.save all

*----------------------------------------------------------------
* NGSPICE control
*----------------------------------------------------------------
.control
load {cicname}.raw
set num_threads=4
set color0=white
set color1=black
unset askquit

.option savecurrents

*optran 0 0 0 1n 1u 0
*dc temp -40 125 1
*write {cicname}_temp.raw

*op
*write {cicname}_op.raw

*tran 0.1n 2u 1p
*write
*quit

echo 'Temp ; Freq' > oscillator.csv

let tcur = -20
while tcur le 100
	alterparam TAMB = $&tcur
	reset

        tran 0.1n 1.5u 1p

	meas tran Tperiod  TRIG v(OSC_TEMP_1V8) VAL=0.9 RISE=1  TARG v(OSC_TEMP_1V8) VAL=0.9 RISE=2
	let Freq = 1/Tperiod
	echo Temp = $&tcur V  freq = $&freq Hz
	echo '$&tcur ; $&freq' >> oscillator.csv

	let tcur = tcur + 10

end

*tran 0.1n 1u 1p
*write

quit

.endc

.end
