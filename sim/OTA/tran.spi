*TB_OTA_TRAN
*----------------------------------------------------------------
* Include
*----------------------------------------------------------------
#ifdef Lay
.include ../../../work/lpe/OTA_lpe.spi
#else
.include ../../../work/xsch/OTA.spice
#endif

*-----------------------------------------------------------------
* OPTIONS
*-----------------------------------------------------------------
.option TNOM=27 GMIN=1e-15 reltol=1e-3

*-----------------------------------------------------------------
* PARAMETERS
*-----------------------------------------------------------------
.param TRF = 10p
.param AVDD = {vdda}
.param FREQ = 1e6

*-----------------------------------------------------------------
* FORCE
*-----------------------------------------------------------------
VSS  VSS  0     dc 0
VDD  VDD_1V8  VSS  dc 1.8
VPWRUP PWRUP_1V8 VSS dc 1.8

* Differential input: 10mV amplitude sine at 1MHz around 0.9V common mode
VINP Vinp VSS SIN(0.9 0.01 {FREQ} 0 0 0)
VINN Vinn VSS SIN(0.9 0.01 {FREQ} 0 0 180)

*-----------------------------------------------------------------
* DUT
*-----------------------------------------------------------------
XDUT VDD_1V8 PWRUP_1V8 Vout Vinn Vinp VSS OTA

*----------------------------------------------------------------
* PROBE
*----------------------------------------------------------------
.option savecurrents
.save all

*----------------------------------------------------------------
* NGSPICE control
*----------------------------------------------------------------
.control
set num_threads=8
set color0=white
set color1=black
unset askquit

optran 0 0 0 1n 1u 0

* Run for 10 cycles at 1MHz = 10us
tran 10n 10u 1p

write
quit

.endc

.end
