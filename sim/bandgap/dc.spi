*TB_SUN_TR_SKY130NM/TB_NCM
*----------------------------------------------------------------
* Include
*----------------------------------------------------------------
#ifdef Lay
.include ../../../work/lpe/bandgap_lpe.spi
#else
.include ../../../work/xsch/bandgap.spice
#endif

*-----------------------------------------------------------------
* OPTIONS
*-----------------------------------------------------------------
.option TNOM=27 GMIN=1e-15 reltol=1e-3

*-----------------------------------------------------------------
* PARAMETERS
*-----------------------------------------------------------------
.param TRF = 10p
.param vdda = 1.8
.param AVDD = {vdda}

*-----------------------------------------------------------------
* FORCE
*-----------------------------------------------------------------
VSS  VSS  0     dc 0
VDD_1V8  VDD_1V8  VSS  dc 1.8

VPWR  PWRUP_1V8  VSS  dc {AVDD}
VPWRN  PWRUP_N_1V8  VSS  dc 0

R_IPTAT_MEAS IPTAT 0 1k

*-----------------------------------------------------------------
* DUT
*-----------------------------------------------------------------
.include ../xdut.spi

*----------------------------------------------------------------
* PROBE
*----------------------------------------------------------------
.options savecurrents
.save all
.save v(vref) @m.xdut.x8.msky130_fd_pr__pfet_01v8_lvt[id]

*----------------------------------------------------------------
* NGSPICE control
*----------------------------------------------------------------
.control
load {cicname}.raw
set num_threads=16
set color0=white
set color1=black
unset askquit

optran 0 0 0 0.5n 2u 0
op

dc temp -40 125 1
write {cicname}_temp.raw

quit

.endc

.end
