*TB_SUN_TR_SKY130NM/TB_NCM
*----------------------------------------------------------------
* Include
*----------------------------------------------------------------
#ifdef Lay
.include ../../../work/lpe/bandgap_lpe.spi
#else
.include ../../../work/xsch/bandgap.spice
#endif

*-----------------------------------------------------------------
* OPTIONS
*-----------------------------------------------------------------
.option method=gear klu TNOM=27 GMIN=1e-15 reltol=1e-3 gminsteps=100 rshunt=1e12 dcconv=1 chgtol=1e-16
*-----------------------------------------------------------------
* PARAMETERS
*-----------------------------------------------------------------
.param TRF = 10p
.param AVDD = {vdda}

*-----------------------------------------------------------------
* FORCE
*-----------------------------------------------------------------
VSS  VSS  0     dc 0
VDD_1V8  VDD_1V8  VSS  dc {vdda}

VPWR     PWRUP_1V8   VSS  dc 1.8
VPWRN    PWRUP_N_1V8 VSS  dc 0

*VPWR  PWRUP_1V8  VSS  pwl 0 0 {t_start} 0 {{t_start}+10p} {AVDD}
*VPWRN  PWRUP_N_1V8  VSS  pwl 0 {AVDD} {t_start} {AVDD} {{t_start}+10p} {0}

R_IPTAT_MEAS IPTAT 0 1k

*-----------------------------------------------------------------
* DUT
*-----------------------------------------------------------------
.include ../xdut.spi

*----------------------------------------------------------------
* PROBE
*----------------------------------------------------------------
.options savecurrents
.save all

.save i(@R_IPTAT_MEAS[i]) i(VDD_1V8) v(xdut.x1.tail) v(vref)
*----------------------------------------------------------------
* NGSPICE control
*----------------------------------------------------------------
.control

set num_threads=6
set color0=white
set color1=black
unset askquit

ic v(VOUT)=1.2 v(VIP)=0.85 v(VIN)=0.85

set itl1=1000
set itl2=1000

*op uic

optran 0 0 0 1n 1u 0
run

dc temp -50 125 1

write {cicname}_temp.raw

tran 10n 10u 1p
write
quit

.endc

.end
