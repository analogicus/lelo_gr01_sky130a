*TB_DIFFAMP_1_AC_VCM - Sweep VCM to find optimal open-loop gain
*----------------------------------------------------------------
* Include
*----------------------------------------------------------------
#ifdef Lay
.include ../../../work/lpe/diffamp_1_lpe.spi
#else
.include ../../../work/xsch/diffamp_1.spice
#endif

*-----------------------------------------------------------------
* OPTIONS
*-----------------------------------------------------------------
.option TNOM=27 GMIN=1e-15 reltol=1e-3

*-----------------------------------------------------------------
* PARAMETERS
*-----------------------------------------------------------------
.param AVDD = {vdda}

*-----------------------------------------------------------------
* FORCE
*-----------------------------------------------------------------
VSS  VSS  0     dc 0
VDD  VDD_1V8  VSS  dc {AVDD}

VIP  VIP  VSS  dc 0.6 AC 1
VIN  VIN  VSS  dc 0.6

VPWR  xdut.PWRUP_1V8  VSS  dc {AVDD}
VPWRN  xdut.PWRUP_N_1V8  VSS  dc 0

* Output load capacitor
CL   VOUT  VSS  0.25f

*-----------------------------------------------------------------
* DUT
*-----------------------------------------------------------------
.include ../xdut.spi

*----------------------------------------------------------------
* PROBE
*----------------------------------------------------------------
.save all

*----------------------------------------------------------------
* NGSPICE control – VCM sweep
*----------------------------------------------------------------
.control
set num_threads=8
set color0=white
set color1=black
unset askquit

echo "vcm dc_gain_db ugbw_hz phase_margin_deg" > {cicname}.csv

foreach vcm_val 0.20 0.25 0.30 0.35 0.40 0.45 0.50 0.55 0.60 0.65 0.70 0.75 0.80 0.85 0.90 0.95 1.00 1.05 1.10 1.15 1.20 1.25 1.30
  alter @vip[dc] = $vcm_val
  alter @vin[dc] = $vcm_val

  optran 0 0 0 1n 1u 0
  op
  ac dec 50 1 10G

  let vout_db   = db(v(vout))
  let vout_phase = 180/pi * cph(v(vout))

  meas ac dc_gain      find vout_db    at=10
  meas ac my_ugbw      when vout_db=0  fall=1
  meas ac ph_at_ugbw   find vout_phase at=my_ugbw
  let my_pm = 180 + ph_at_ugbw

  echo "$vcm_val $&dc_gain $&my_ugbw $&my_pm" >> {cicname}.csv

  destroy all
end

quit

.endc

.end
