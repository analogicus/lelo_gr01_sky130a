*TB_SUN_TR_SKY130NM/TB_NCM
*----------------------------------------------------------------
* Include
*----------------------------------------------------------------
#ifdef Lay
.include ../../../work/lpe/oscillator_tb_lpe.spi
#else
.include ../../../work/xsch/oscillator_tb.spice
#endif

*-----------------------------------------------------------------
* OPTIONS
*-----------------------------------------------------------------
.option TNOM=27 GMIN=1e-15 reltol=1e-3

*-----------------------------------------------------------------
* PARAMETERS
*-----------------------------------------------------------------
.param TRF = 10p
.param vdda = 1.8
.param AVDD = {vdda}

.param TAMB = 27
.temp {TAMB}

*-----------------------------------------------------------------
* FORCE
*-----------------------------------------------------------------
VSS  VSS  0     dc 0
VDD_1V8  VDD_1V8  VSS  dc 1.8

IB_OSC   VDD_1V8  IB_OSC  dc 10u
IB_BG   VDD_1V8  IB_BG  dc 10u

*VREF  VREF  VSS  dc 1.22

*VBG  VBG  VSS  dc 0.7

*-----------------------------------------------------------------
* DUT
*-----------------------------------------------------------------
.include ../xdut.spi

*----------------------------------------------------------------
* PROBE
*----------------------------------------------------------------
.options savecurrents
.save all

*----------------------------------------------------------------
* NGSPICE control
*----------------------------------------------------------------
.control
load {cicname}.raw
set num_threads=16
set color0=white
set color1=black
unset askquit

.option savecurrents

op
tran 0.5n 2.5u 1p
write

echo 'Temp ; Freq' > {cicname}_oscillator.csv

set temp_stop = 125
set temp_step = 15
set temp_val = -40
while $temp_val le $temp_stop
	alterparam TAMB = $temp_val
	reset

	tran 0.25n 4u 1p

	meas tran Tperiod  TRIG v(vout_osc) VAL=0.9 RISE=2  TARG v(vout_osc) VAL=0.9 RISE=3
	let Freq = 1/Tperiod
	echo Temp = $temp_val C  freq = $&freq Hz
	echo '$temp_val ; $&freq' >> {cicname}_oscillator.csv

	let temp_next = $temp_val + $temp_step
	set temp_val = "$&temp_next"
end

quit

.endc

.end
